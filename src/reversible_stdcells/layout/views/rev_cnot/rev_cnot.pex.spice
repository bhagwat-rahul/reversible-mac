* NGSPICE file created from rev_cnot.ext - technology: sky130A

.subckt rev_cnot VDD VGND A B A_OUT B_OUT
X0 VDD B a_652_110# VDD sky130_fd_pr__pfet_01v8 ad=0.3 pd=2.6 as=0.3 ps=2.6 w=1 l=0.15
X1 VGND A a_346_110# VGND sky130_fd_pr__nfet_01v8 ad=0.3 pd=2.6 as=0.3 ps=2.6 w=1 l=0.15
V0 A A_OUT 0
X2 VGND B a_652_110# VGND sky130_fd_pr__nfet_01v8 ad=0.3 pd=2.6 as=0.3 ps=2.6 w=1 l=0.15
X3 B A B_OUT VDD sky130_fd_pr__pfet_01v8 ad=0.3 pd=2.6 as=0.3 ps=2.6 w=1 l=0.15
X4 a_652_110# a_346_110# B_OUT VDD sky130_fd_pr__pfet_01v8 ad=0.3 pd=2.6 as=0.3 ps=2.6 w=1 l=0.15
X5 B a_346_110# B_OUT VGND sky130_fd_pr__nfet_01v8 ad=0.3 pd=2.6 as=0.3 ps=2.6 w=1 l=0.15
X6 a_652_110# A B_OUT VGND sky130_fd_pr__nfet_01v8 ad=0.3 pd=2.6 as=0.3 ps=2.6 w=1 l=0.15
X7 VDD A a_346_110# VDD sky130_fd_pr__pfet_01v8 ad=0.3 pd=2.6 as=0.3 ps=2.6 w=1 l=0.15
C0 a_652_110# B_OUT 0.45141f
C1 a_652_110# B 0.33816f
C2 a_652_110# A 0.49479f
C3 B B_OUT 0.65211f
C4 A B_OUT 0.31446f
C5 A B 0.38698f
C6 VDD a_652_110# 0.38028f
C7 VDD B_OUT 0.13788f
C8 a_652_110# a_346_110# 0.23444f
C9 VDD B 0.83247f
C10 VDD A 0.71608f
C11 B_OUT a_346_110# 0.41245f
C12 B a_346_110# 0.24568f
C13 A a_346_110# 0.72069f
C14 VDD a_346_110# 0.76629f
C15 B_OUT VGND 0.99492f
C16 VDD VGND 3.98575f
C17 a_652_110# VGND 1.69781f
.ends
