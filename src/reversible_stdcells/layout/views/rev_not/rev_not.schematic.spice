** sch_path: /foss/designs/current-designs/reversible-mac/src/reversible_stdcells/rev_not/rev_not.sch
.subckt rev_not VDD VGND A Y
*.iopin VDD
*.iopin VGND
*.ipin A
*.opin Y
XMP Y A VDD VDD sky130_fd_pr__pfet_01v8 L=0.15 W=1 nf=1 ad=0.29 as=0.29 pd=2.58 ps=2.58 nrd=0.29 nrs=0.29 sa=0 sb=0 sd=0 mult=1
XMN Y A VGND VGND sky130_fd_pr__nfet_01v8 L=0.15 W=1 nf=1 ad=0.29 as=0.29 pd=2.58 ps=2.58 nrd=0.29 nrs=0.29 sa=0 sb=0 sd=0 mult=1
.ends
