* NGSPICE file created from rev_toffoli.ext - technology: sky130A

.subckt rev_toffoli VDD VGND A B C A_OUT B_OUT C_OUT
X0 VDD B a_346_110# VDD sky130_fd_pr__pfet_01v8 ad=0.3 pd=2.6 as=0.3 ps=2.6 w=1 l=0.15
X1 a_436_110# A a_346_110# VGND sky130_fd_pr__nfet_01v8 ad=0.6 pd=4.6 as=0.6 ps=4.6 w=2 l=0.15
V0 B B_OUT 0
V1 A A_OUT 0
X2 VGND B a_436_110# VGND sky130_fd_pr__nfet_01v8 ad=0.6 pd=4.6 as=0.6 ps=4.6 w=2 l=0.15
X3 VDD a_346_110# a_958_110# VDD sky130_fd_pr__pfet_01v8 ad=0.3 pd=2.6 as=0.3 ps=2.6 w=1 l=0.15
X4 VDD C a_1264_110# VDD sky130_fd_pr__pfet_01v8 ad=0.3 pd=2.6 as=0.3 ps=2.6 w=1 l=0.15
X5 VGND a_346_110# a_958_110# VGND sky130_fd_pr__nfet_01v8 ad=0.3 pd=2.6 as=0.3 ps=2.6 w=1 l=0.15
X6 C a_958_110# C_OUT VDD sky130_fd_pr__pfet_01v8 ad=0.3 pd=2.6 as=0.3 ps=2.6 w=1 l=0.15
X7 VGND C a_1264_110# VGND sky130_fd_pr__nfet_01v8 ad=0.3 pd=2.6 as=0.3 ps=2.6 w=1 l=0.15
X8 a_1264_110# a_346_110# C_OUT VDD sky130_fd_pr__pfet_01v8 ad=0.3 pd=2.6 as=0.3 ps=2.6 w=1 l=0.15
X9 C a_346_110# C_OUT VGND sky130_fd_pr__nfet_01v8 ad=0.3 pd=2.6 as=0.3 ps=2.6 w=1 l=0.15
X10 VDD A a_346_110# VDD sky130_fd_pr__pfet_01v8 ad=0.3 pd=2.6 as=0.3 ps=2.6 w=1 l=0.15
X11 a_1264_110# a_958_110# C_OUT VGND sky130_fd_pr__nfet_01v8 ad=0.3 pd=2.6 as=0.3 ps=2.6 w=1 l=0.15
C0 A C_OUT 0.06249f
C1 a_958_110# a_1264_110# 0.23132f
C2 A C 0.17918f
C3 A a_436_110# 0.14418f
C4 A a_1264_110# 0.27903f
C5 A a_958_110# 0.09131f
C6 a_346_110# C_OUT 0.41767f
C7 a_346_110# C 0.34744f
C8 a_346_110# a_436_110# 0.21066f
C9 a_346_110# a_1264_110# 0.49399f
C10 VDD C_OUT 0.14775f
C11 a_346_110# a_958_110# 0.47998f
C12 VDD C 0.67177f
C13 VDD a_436_110# 0.02879f
C14 VDD a_1264_110# 0.21885f
C15 A a_346_110# 0.37725f
C16 VDD a_958_110# 0.36444f
C17 C_OUT B 0.084f
C18 C B 0.50679f
C19 A VDD 0.30979f
C20 B a_436_110# 0.05324f
C21 a_1264_110# B 0.0683f
C22 a_958_110# B 0.51849f
C23 A B 0.74096f
C24 a_346_110# VDD 1.33628f
C25 C C_OUT 0.67143f
C26 a_346_110# B 0.19831f
C27 C_OUT a_1264_110# 0.43417f
C28 C a_436_110# 0.00225f
C29 a_958_110# C_OUT 0.32776f
C30 C a_1264_110# 0.22882f
C31 VDD B 0.24903f
C32 C a_958_110# 0.51237f
C33 a_958_110# a_436_110# 0.00364f
C34 C_OUT VGND 1.20156f
C35 VDD VGND 5.23277f
C36 a_436_110# VGND 0.99871f
C37 a_1264_110# VGND 1.30666f
.ends
