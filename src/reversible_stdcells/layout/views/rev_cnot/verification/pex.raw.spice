* NGSPICE file created from rev_cnot.ext - technology: sky130A

.subckt rev_cnot VDD VGND A B A_OUT B_OUT
X0 VDD B a_652_110# VDD sky130_fd_pr__pfet_01v8 ad=0.3 pd=2.6 as=0.3 ps=2.6 w=1 l=0.15
X1 VGND A_OUT a_346_110# VGND sky130_fd_pr__nfet_01v8 ad=0.3 pd=2.6 as=0.3 ps=2.6 w=1 l=0.15
V0 A_OUT A 0.0
X2 VGND B a_652_110# VGND sky130_fd_pr__nfet_01v8 ad=0.3 pd=2.6 as=0.3 ps=2.6 w=1 l=0.15
X3 B A_OUT B_OUT VDD sky130_fd_pr__pfet_01v8 ad=0.3 pd=2.6 as=0.3 ps=2.6 w=1 l=0.15
X4 a_652_110# a_346_110# B_OUT VDD sky130_fd_pr__pfet_01v8 ad=0.3 pd=2.6 as=0.3 ps=2.6 w=1 l=0.15
X5 B a_346_110# B_OUT VGND sky130_fd_pr__nfet_01v8 ad=0.3 pd=2.6 as=0.3 ps=2.6 w=1 l=0.15
X6 a_652_110# A_OUT B_OUT VGND sky130_fd_pr__nfet_01v8 ad=0.3 pd=2.6 as=0.3 ps=2.6 w=1 l=0.15
X7 VDD A_OUT a_346_110# VDD sky130_fd_pr__pfet_01v8 ad=0.3 pd=2.6 as=0.3 ps=2.6 w=1 l=0.15
C0 VDD a_346_110# 0.70144f
C1 a_652_110# B_OUT 0.37831f
C2 a_652_110# B 0.17215f
C3 a_652_110# A_OUT 0.34919f
C4 B B_OUT 0.68537f
C5 A_OUT B_OUT 0.3932f
C6 A_OUT B 0.69102f
C7 VDD a_652_110# 0.38342f
C8 VDD B_OUT 0.14298f
C9 a_652_110# a_346_110# 0.45466f
C10 VDD B 0.54749f
C11 VDD A_OUT 0.68149f
C12 B_OUT a_346_110# 0.31964f
C13 B a_346_110# 0.29104f
C14 A_OUT a_346_110# 0.58502f
C15 B_OUT VGND 1.15213f
C16 VDD VGND 3.08698f
C17 a_652_110# VGND 1.84472f
.ends
