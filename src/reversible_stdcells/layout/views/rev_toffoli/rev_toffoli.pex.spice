* NGSPICE file created from rev_toffoli.ext - technology: sky130A

.subckt rev_toffoli VDD VGND A B C A_OUT B_OUT C_OUT
X0 VDD B a_346_110# VDD sky130_fd_pr__pfet_01v8 ad=0.3 pd=2.6 as=0.3 ps=2.6 w=1 l=0.15
X1 a_436_110# A a_346_110# VGND sky130_fd_pr__nfet_01v8 ad=0.6 pd=4.6 as=0.6 ps=4.6 w=2 l=0.15
V0 B B_OUT 0
V1 A A_OUT 0
X2 VGND B a_436_110# VGND sky130_fd_pr__nfet_01v8 ad=0.6 pd=4.6 as=0.6 ps=4.6 w=2 l=0.15
X3 VDD a_346_110# a_958_110# VDD sky130_fd_pr__pfet_01v8 ad=0.3 pd=2.6 as=0.3 ps=2.6 w=1 l=0.15
X4 VDD C a_1264_110# VDD sky130_fd_pr__pfet_01v8 ad=0.3 pd=2.6 as=0.3 ps=2.6 w=1 l=0.15
X5 VGND a_346_110# a_958_110# VGND sky130_fd_pr__nfet_01v8 ad=0.3 pd=2.6 as=0.3 ps=2.6 w=1 l=0.15
X6 C a_958_110# C_OUT VDD sky130_fd_pr__pfet_01v8 ad=0.3 pd=2.6 as=0.3 ps=2.6 w=1 l=0.15
X7 VGND C a_1264_110# VGND sky130_fd_pr__nfet_01v8 ad=0.3 pd=2.6 as=0.3 ps=2.6 w=1 l=0.15
X8 a_1264_110# a_346_110# C_OUT VDD sky130_fd_pr__pfet_01v8 ad=0.3 pd=2.6 as=0.3 ps=2.6 w=1 l=0.15
X9 C a_346_110# C_OUT VGND sky130_fd_pr__nfet_01v8 ad=0.3 pd=2.6 as=0.3 ps=2.6 w=1 l=0.15
X10 VDD A a_346_110# VDD sky130_fd_pr__pfet_01v8 ad=0.3 pd=2.6 as=0.3 ps=2.6 w=1 l=0.15
X11 a_1264_110# a_958_110# C_OUT VGND sky130_fd_pr__nfet_01v8 ad=0.3 pd=2.6 as=0.3 ps=2.6 w=1 l=0.15
C0 A a_958_110# 0.09131f
C1 a_346_110# C_OUT 0.41767f
C2 a_346_110# C 0.34744f
C3 a_346_110# a_436_110# 0.21066f
C4 a_346_110# a_1264_110# 0.49399f
C5 VDD C_OUT 0.14775f
C6 a_346_110# a_958_110# 0.47998f
C7 VDD C 0.67177f
C8 VDD a_436_110# 0.02879f
C9 VDD a_1264_110# 0.21885f
C10 A a_346_110# 0.37725f
C11 VDD a_958_110# 0.36444f
C12 C_OUT B 0.084f
C13 C B 0.50679f
C14 A VDD 0.30979f
C15 B a_436_110# 0.05324f
C16 a_1264_110# B 0.0683f
C17 a_958_110# B 0.51849f
C18 A B 0.74096f
C19 a_346_110# VDD 1.33628f
C20 C C_OUT 0.67143f
C21 a_346_110# B 0.19831f
C22 C_OUT a_1264_110# 0.43417f
C23 C a_436_110# 0.00225f
C24 a_958_110# C_OUT 0.32776f
C25 C a_1264_110# 0.22882f
C26 VDD B 0.24903f
C27 C a_958_110# 0.51237f
C28 a_958_110# a_436_110# 0.00364f
C29 A C_OUT 0.06249f
C30 a_958_110# a_1264_110# 0.23132f
C31 A C 0.17918f
C32 A a_436_110# 0.14418f
C33 A a_1264_110# 0.27903f
C34 C_OUT VGND 1.20156f
C35 VDD VGND 5.23277f
C36 a_436_110# VGND 0.99871f
C37 a_1264_110# VGND 1.30666f
.ends
